** CMOS Dual Current-Starved VCO + VPTAT — LVS reference netlist
** Vittoz PTAT core, all SG13CMOS devices (no BJT/HBT)
** W values = PCell total width (KLayout extracts merged W for multi-finger)
.subckt ptat_vco vdd gnd net_c1 net_c2 net_rptat nmos_bias pmos_bias vptat
+ vco1 vco2 vco3 vco4 vco5 ns1 ns2 ns3 ns4 ns5 nb1 nb2 nb3 nb4 nb5
+ buf1 vco_out

** ── PTAT core: PMOS mirror (L=100u) ──
MPM3 net_c1 net_c1 vdd vdd sg13_lv_pmos w=0.5u l=100u
MPM4 net_c2 net_c1 vdd vdd sg13_lv_pmos w=0.5u l=100u
MPM_ref nmos_bias net_c1 vdd vdd sg13_lv_pmos w=0.5u l=100u
MPM5 vptat net_c1 vdd vdd sg13_lv_pmos w=0.5u l=100u

** ── PTAT core: NMOS Vittoz pair ──
MMN1 net_c1 net_c1 gnd gnd sg13_lv_nmos w=2u l=4u
MMN2 net_c2 net_c1 net_rptat gnd sg13_lv_nmos w=16u l=4u

** ── PTAT resistor (rhigh) ──
RRptat net_rptat gnd rhigh w=0.5u l=134.09u ps=0.18u b=12 m=1

** ── VPTAT output resistor (rppd) ──
RRout vptat gnd rppd w=0.5u l=25.915u ps=0.18u b=4 m=1

** ── NMOS bias generation ──
MMN_diode nmos_bias nmos_bias gnd gnd sg13_lv_nmos w=1u l=2u
MMN_pgen pmos_bias nmos_bias gnd gnd sg13_lv_nmos w=1u l=2u

** ── PMOS bias generation ──
MPM_pdiode pmos_bias pmos_bias vdd vdd sg13_lv_pmos w=0.5u l=2u

** ── 5-stage dual current-starved ring VCO ──
** PMOS current sources (ng=8, total W=4u)
MMpb1 ns1 pmos_bias vdd vdd sg13_lv_pmos w=4u l=2u
MMpb2 ns2 pmos_bias vdd vdd sg13_lv_pmos w=4u l=2u
MMpb3 ns3 pmos_bias vdd vdd sg13_lv_pmos w=4u l=2u
MMpb4 ns4 pmos_bias vdd vdd sg13_lv_pmos w=4u l=2u
MMpb5 ns5 pmos_bias vdd vdd sg13_lv_pmos w=4u l=2u

** PMOS pull-up inverters
MMpu1 vco1 vco5 ns1 vdd sg13_lv_pmos w=2u l=0.5u
MMpu2 vco2 vco1 ns2 vdd sg13_lv_pmos w=2u l=0.5u
MMpu3 vco3 vco2 ns3 vdd sg13_lv_pmos w=2u l=0.5u
MMpu4 vco4 vco3 ns4 vdd sg13_lv_pmos w=2u l=0.5u
MMpu5 vco5 vco4 ns5 vdd sg13_lv_pmos w=2u l=0.5u

** NMOS pull-down inverters
MMpd1 vco1 vco5 nb1 gnd sg13_lv_nmos w=1u l=0.5u
MMpd2 vco2 vco1 nb2 gnd sg13_lv_nmos w=1u l=0.5u
MMpd3 vco3 vco2 nb3 gnd sg13_lv_nmos w=1u l=0.5u
MMpd4 vco4 vco3 nb4 gnd sg13_lv_nmos w=1u l=0.5u
MMpd5 vco5 vco4 nb5 gnd sg13_lv_nmos w=1u l=0.5u

** NMOS current sources (ng=8, total W=8u)
MMnb1 nb1 nmos_bias gnd gnd sg13_lv_nmos w=8u l=2u
MMnb2 nb2 nmos_bias gnd gnd sg13_lv_nmos w=8u l=2u
MMnb3 nb3 nmos_bias gnd gnd sg13_lv_nmos w=8u l=2u
MMnb4 nb4 nmos_bias gnd gnd sg13_lv_nmos w=8u l=2u
MMnb5 nb5 nmos_bias gnd gnd sg13_lv_nmos w=8u l=2u

** ── Output buffer ──
MMbp1 buf1 vco5 vdd vdd sg13_lv_pmos w=4u l=0.5u
MMbn1 buf1 vco5 gnd gnd sg13_lv_nmos w=2u l=0.5u
MMbp2 vco_out buf1 vdd vdd sg13_lv_pmos w=8u l=0.5u
MMbn2 vco_out buf1 gnd gnd sg13_lv_nmos w=4u l=0.5u

.ends ptat_vco
.end
