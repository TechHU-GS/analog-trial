.subckt soilz gnd vdd
MPM3 net_c1 net_c1 vdd vdd sg13_lv_pmos w=0.5u l=10u ng=1 m=1
MPM4 net_c2 net_c1 vdd vdd sg13_lv_pmos w=0.5u l=10u ng=1 m=1
MMN1 net_c1 net_c1 0 0 sg13_lv_nmos w=2u l=4u ng=1 m=1
MMN2 net_c2 net_c1 net_rptat 0 sg13_lv_nmos w=16u l=4u ng=8 m=1
RRptat net_rptat 0 0 rhigh w=0.5e-6 l=133.0e-6 b=12 m=1
MPM_ref nmos_bias net_c1 vdd vdd sg13_lv_pmos w=0.5u l=10u ng=1 m=1
MMN_diode nmos_bias nmos_bias 0 0 sg13_lv_nmos w=1u l=2u ng=1 m=1
MMN_pgen pmos_bias nmos_bias 0 0 sg13_lv_nmos w=1u l=2u ng=1 m=1
MPM_pdiode pmos_bias pmos_bias vdd vdd sg13_lv_pmos w=0.5u l=2u ng=1 m=1
MPM5 vptat net_c1 vdd vdd sg13_lv_pmos w=0.5u l=10u ng=1 m=1
RRout vptat 0 0 rppd w=0.5e-6 l=25.0e-6 b=4 m=1
MMpb1 ns1 pmos_bias vdd vdd sg13_lv_pmos w=4u l=2u ng=8 m=1
MMpu1 vco1 vco5 ns1 vdd sg13_lv_pmos w=2u l=0.5u ng=1 m=1
MMpd1 vco1 vco5 nb1 0 sg13_lv_nmos w=1u l=0.5u ng=1 m=1
MMnb1 nb1 nmos_bias 0 0 sg13_lv_nmos w=8u l=2u ng=8 m=1
MMpb2 ns2 pmos_bias vdd vdd sg13_lv_pmos w=4u l=2u ng=8 m=1
MMpu2 vco2 vco1 ns2 vdd sg13_lv_pmos w=2u l=0.5u ng=1 m=1
MMpd2 vco2 vco1 nb2 0 sg13_lv_nmos w=1u l=0.5u ng=1 m=1
MMnb2 nb2 nmos_bias 0 0 sg13_lv_nmos w=8u l=2u ng=8 m=1
MMpb3 ns3 pmos_bias vdd vdd sg13_lv_pmos w=4u l=2u ng=8 m=1
MMpu3 vco3 vco2 ns3 vdd sg13_lv_pmos w=2u l=0.5u ng=1 m=1
MMpd3 vco3 vco2 nb3 0 sg13_lv_nmos w=1u l=0.5u ng=1 m=1
MMnb3 nb3 nmos_bias 0 0 sg13_lv_nmos w=8u l=2u ng=8 m=1
MMpb4 ns4 pmos_bias vdd vdd sg13_lv_pmos w=4u l=2u ng=8 m=1
MMpu4 vco4 vco3 ns4 vdd sg13_lv_pmos w=2u l=0.5u ng=1 m=1
MMpd4 vco4 vco3 nb4 0 sg13_lv_nmos w=1u l=0.5u ng=1 m=1
MMnb4 nb4 nmos_bias 0 0 sg13_lv_nmos w=8u l=2u ng=8 m=1
MMpb5 ns5 pmos_bias vdd vdd sg13_lv_pmos w=4u l=2u ng=8 m=1
MMpu5 vco5 vco4 ns5 vdd sg13_lv_pmos w=2u l=0.5u ng=1 m=1
MMpd5 vco5 vco4 nb5 0 sg13_lv_nmos w=1u l=0.5u ng=1 m=1
MMnb5 nb5 nmos_bias 0 0 sg13_lv_nmos w=8u l=2u ng=8 m=1
MMBp1 buf1 vco5 vdd vdd sg13_lv_pmos w=4u l=0.5u ng=1 m=1
MMBn1 buf1 vco5 0 0 sg13_lv_nmos w=2u l=0.5u ng=1 m=1
MMBp2 vco_out buf1 vdd vdd sg13_lv_pmos w=8u l=0.5u ng=2 m=1
MMBn2 vco_out buf1 0 0 sg13_lv_nmos w=4u l=0.5u ng=2 m=1
MPM_cas_ref cas_ref net_c1 vdd vdd sg13_lv_pmos w=1u l=10u ng=1 m=1
MPM_cas_diode vcas vcas cas_ref vdd sg13_lv_pmos w=1u l=2u ng=1 m=1
MMN_cas_load vcas vcas 0 0 sg13_lv_nmos w=0.5u l=2u ng=1 m=1
MPM_mir1 cas1 net_c1 vdd vdd sg13_lv_pmos w=1u l=10u ng=1 m=1
MPM_cas1 src1 vcas cas1 vdd sg13_lv_pmos w=1u l=2u ng=1 m=1
MPM_mir2 cas2 net_c1 vdd vdd sg13_lv_pmos w=2u l=10u ng=1 m=1
MPM_cas2 src2 vcas cas2 vdd sg13_lv_pmos w=2u l=2u ng=1 m=1
MPM_mir3 cas3 net_c1 vdd vdd sg13_lv_pmos w=4u l=10u ng=2 m=1
MPM_cas3 src3 vcas cas3 vdd sg13_lv_pmos w=4u l=2u ng=2 m=1
MSW1n src1 sel0 exc_out 0 sg13_lv_nmos w=2u l=0.5u ng=1 m=1
MSW1p src1 sel0b exc_out vdd sg13_lv_pmos w=4u l=0.5u ng=1 m=1
MSW2n src2 sel1 exc_out 0 sg13_lv_nmos w=2u l=0.5u ng=1 m=1
MSW2p src2 sel1b exc_out vdd sg13_lv_pmos w=4u l=0.5u ng=1 m=1
MSW3n src3 sel2 exc_out 0 sg13_lv_nmos w=2u l=0.5u ng=1 m=1
MSW3p src3 sel2b exc_out vdd sg13_lv_pmos w=4u l=0.5u ng=1 m=1
MMS1 exc_out phi_p probe_p 0 sg13_lv_nmos w=4u l=0.5u ng=2 m=1
MMS2 0 phi_n probe_p 0 sg13_lv_nmos w=4u l=0.5u ng=2 m=1
MMS3 exc_out phi_n probe_n 0 sg13_lv_nmos w=4u l=0.5u ng=2 m=1
MMS4 0 phi_p probe_n 0 sg13_lv_nmos w=4u l=0.5u ng=2 m=1
MMchop1n sens_p f_exc chop_out 0 sg13_lv_nmos w=2u l=0.5u ng=1 m=1
MMchop1p sens_p f_exc_b chop_out vdd sg13_lv_pmos w=4u l=0.5u ng=1 m=1
MMchop2n sens_n f_exc_b chop_out 0 sg13_lv_nmos w=2u l=0.5u ng=1 m=1
MMchop2p sens_n f_exc chop_out vdd sg13_lv_pmos w=4u l=0.5u ng=1 m=1
MMbias_d bias_n bias_n 0 0 sg13_lv_nmos w=4u l=4u ng=1 m=1
MMp_load_p mid_p mid_p vdd vdd sg13_lv_pmos w=4u l=4u ng=1 m=1
MMp_load_n ota_out mid_p vdd vdd sg13_lv_pmos w=4u l=4u ng=1 m=1
MMin_p mid_p vref_ota tail 0 sg13_lv_nmos w=10u l=2u ng=4 m=1
MMin_n ota_out sum_n tail 0 sg13_lv_nmos w=10u l=2u ng=4 m=1
MMtail tail bias_n 0 0 sg13_lv_nmos w=8u l=4u ng=2 m=1
MMc_tail c_tail comp_clk 0 0 sg13_lv_nmos w=4u l=0.5u ng=2 m=1
MMc_inp c_di_p ota_out c_tail 0 sg13_lv_nmos w=4u l=0.5u ng=2 m=1
MMc_inn c_di_n vref_comp c_tail 0 sg13_lv_nmos w=4u l=0.5u ng=2 m=1
MMc_rst_dp c_di_p comp_clk vdd vdd sg13_lv_pmos w=2u l=0.5u ng=1 m=1
MMc_rst_dn c_di_n comp_clk vdd vdd sg13_lv_pmos w=2u l=0.5u ng=1 m=1
MMc_ln1 comp_outp comp_outn c_di_p 0 sg13_lv_nmos w=1u l=0.5u ng=1 m=1
MMc_ln2 comp_outn comp_outp c_di_n 0 sg13_lv_nmos w=1u l=0.5u ng=1 m=1
MMc_lp1 comp_outp comp_outn vdd vdd sg13_lv_pmos w=1u l=0.5u ng=1 m=1
MMc_lp2 comp_outn comp_outp vdd vdd sg13_lv_pmos w=1u l=0.5u ng=1 m=1
MMc_rst_op comp_outp comp_clk vdd vdd sg13_lv_pmos w=2u l=0.5u ng=1 m=1
MMc_rst_on comp_outn comp_clk vdd vdd sg13_lv_pmos w=2u l=0.5u ng=1 m=1
MMn1a n1_mid comp_outp 0 0 sg13_lv_nmos w=2u l=0.5u ng=1 m=1
MMp1a lat_q comp_outp vdd vdd sg13_lv_pmos w=2u l=0.5u ng=1 m=1
MMn1b lat_q lat_qb n1_mid 0 sg13_lv_nmos w=2u l=0.5u ng=1 m=1
MMp1b lat_q lat_qb vdd vdd sg13_lv_pmos w=2u l=0.5u ng=1 m=1
MMn2a n2_mid comp_outn 0 0 sg13_lv_nmos w=2u l=0.5u ng=1 m=1
MMp2a lat_qb comp_outn vdd vdd sg13_lv_pmos w=2u l=0.5u ng=1 m=1
MMn2b lat_qb lat_q n2_mid 0 sg13_lv_nmos w=2u l=0.5u ng=1 m=1
MMp2b lat_qb lat_q vdd vdd sg13_lv_pmos w=2u l=0.5u ng=1 m=1
MMdac_tg1n dac_hi lat_q dac_out 0 sg13_lv_nmos w=2u l=0.5u ng=1 m=1
MMdac_tg1p dac_hi lat_qb dac_out vdd sg13_lv_pmos w=4u l=0.5u ng=1 m=1
MMdac_tg2n dac_lo lat_qb dac_out 0 sg13_lv_nmos w=2u l=0.5u ng=1 m=1
MMdac_tg2p dac_lo lat_q dac_out vdd sg13_lv_pmos w=4u l=0.5u ng=1 m=1
RRin chop_out sum_n 0 rhigh w=0.5e-6 l=20.0e-6 b=2 m=1
RRdac dac_out sum_n 0 rhigh w=0.5e-6 l=20.0e-6 b=2 m=1
CC_fb ota_out sum_n cap_cmim w=26.0e-6 l=26.0e-6 m=1
.ends soilz
