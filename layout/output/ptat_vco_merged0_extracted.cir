* Extracted by KLayout with SG13G2 LVS runset on : 15/03/2026 19:49

.SUBCKT ptat_vco gnd net_rptat vptat net_c2 nmos_bias nb1 nb2 nb3 nb4 nb5 vco5
+ buf1 vco1 vco2 vco3 vco4 vco_out ns1 vdd ns2 ns3 ns4 ns5 pmos_bias net_c1
R$1 gnd net_rptat rhigh w=0.5u l=134.09u ps=0.18u b=12 m=1
R$2 gnd vptat rppd w=0.5u l=25.915u ps=0.18u b=4 m=1
M$3 vdd pmos_bias pmos_bias vdd sg13_lv_pmos L=2u W=0.5u AS=0.17p AD=0.17p
+ PS=1.68u PD=1.68u
M$4 vdd net_c1 net_c2 vdd sg13_lv_pmos L=100u W=0.5u AS=0.17p AD=0.17p PS=1.68u
+ PD=1.68u
M$5 vdd net_c1 nmos_bias vdd sg13_lv_pmos L=100u W=0.5u AS=0.17p AD=0.17p
+ PS=1.68u PD=1.68u
M$6 vdd net_c1 vptat vdd sg13_lv_pmos L=100u W=0.5u AS=0.17p AD=0.17p PS=1.68u
+ PD=1.68u
M$7 vdd net_c1 net_c1 vdd sg13_lv_pmos L=100u W=0.5u AS=0.17p AD=0.17p PS=1.68u
+ PD=1.68u
M$8 ns1 vco5 vco1 vdd sg13_lv_pmos L=0.5u W=2u AS=0.68p AD=0.68p PS=4.68u
+ PD=4.68u
M$9 ns5 vco4 vco5 vdd sg13_lv_pmos L=0.5u W=2u AS=0.68p AD=0.68p PS=4.68u
+ PD=4.68u
M$10 ns4 vco3 vco4 vdd sg13_lv_pmos L=0.5u W=2u AS=0.68p AD=0.68p PS=4.68u
+ PD=4.68u
M$11 ns3 vco2 vco3 vdd sg13_lv_pmos L=0.5u W=2u AS=0.68p AD=0.68p PS=4.68u
+ PD=4.68u
M$12 ns2 vco1 vco2 vdd sg13_lv_pmos L=0.5u W=2u AS=0.68p AD=0.68p PS=4.68u
+ PD=4.68u
M$13 nb1 vco5 vco1 gnd sg13_lv_nmos L=0.5u W=1u AS=0.34p AD=0.34p PS=2.68u
+ PD=2.68u
M$14 nb5 vco4 vco5 gnd sg13_lv_nmos L=0.5u W=1u AS=0.34p AD=0.34p PS=2.68u
+ PD=2.68u
M$15 nb4 vco3 vco4 gnd sg13_lv_nmos L=0.5u W=1u AS=0.34p AD=0.34p PS=2.68u
+ PD=2.68u
M$16 nb3 vco2 vco3 gnd sg13_lv_nmos L=0.5u W=1u AS=0.34p AD=0.34p PS=2.68u
+ PD=2.68u
M$17 nb2 vco1 vco2 gnd sg13_lv_nmos L=0.5u W=1u AS=0.34p AD=0.34p PS=2.68u
+ PD=2.68u
M$18 vdd pmos_bias ns1 vdd sg13_lv_pmos L=2u W=4u AS=0.835p AD=0.835p PS=7.84u
+ PD=7.84u
M$26 vdd pmos_bias ns4 vdd sg13_lv_pmos L=2u W=4u AS=0.835p AD=0.835p PS=7.84u
+ PD=7.84u
M$34 vdd pmos_bias ns3 vdd sg13_lv_pmos L=2u W=4u AS=0.835p AD=0.835p PS=7.84u
+ PD=7.84u
M$42 vdd pmos_bias ns2 vdd sg13_lv_pmos L=2u W=4u AS=0.835p AD=0.835p PS=7.84u
+ PD=7.84u
M$50 vdd pmos_bias ns5 vdd sg13_lv_pmos L=2u W=4u AS=0.835p AD=0.835p PS=7.84u
+ PD=7.84u
M$58 gnd nmos_bias nb1 gnd sg13_lv_nmos L=2u W=8u AS=1.67p AD=1.67p PS=12.34u
+ PD=12.34u
M$66 gnd nmos_bias nb5 gnd sg13_lv_nmos L=2u W=8u AS=1.67p AD=1.67p PS=12.34u
+ PD=12.34u
M$74 gnd nmos_bias nb4 gnd sg13_lv_nmos L=2u W=8u AS=1.67p AD=1.67p PS=12.34u
+ PD=12.34u
M$82 gnd nmos_bias nb3 gnd sg13_lv_nmos L=2u W=8u AS=1.67p AD=1.67p PS=12.34u
+ PD=12.34u
M$90 gnd nmos_bias nb2 gnd sg13_lv_nmos L=2u W=8u AS=1.67p AD=1.67p PS=12.34u
+ PD=12.34u
M$98 vdd buf1 vco_out vdd sg13_lv_pmos L=0.5u W=8u AS=2.12p AD=2.12p PS=13.06u
+ PD=13.06u
M$100 vdd vco5 buf1 vdd sg13_lv_pmos L=0.5u W=4u AS=1.36p AD=1.36p PS=8.68u
+ PD=8.68u
M$101 gnd buf1 vco_out gnd sg13_lv_nmos L=0.5u W=4u AS=1.06p AD=1.06p PS=7.06u
+ PD=7.06u
M$103 gnd vco5 buf1 gnd sg13_lv_nmos L=0.5u W=2u AS=0.68p AD=0.68p PS=4.68u
+ PD=4.68u
M$104 gnd nmos_bias nmos_bias gnd sg13_lv_nmos L=2u W=1u AS=0.34p AD=0.34p
+ PS=2.68u PD=2.68u
M$105 gnd nmos_bias pmos_bias gnd sg13_lv_nmos L=2u W=1u AS=0.34p AD=0.34p
+ PS=2.68u PD=2.68u
M$106 net_rptat net_c1 net_c2 gnd sg13_lv_nmos L=4u W=16u AS=3.34p AD=3.34p
+ PS=21.34u PD=21.34u
M$114 gnd net_c1 net_c1 gnd sg13_lv_nmos L=4u W=2u AS=0.68p AD=0.68p PS=4.68u
+ PD=4.68u
.ENDS ptat_vco
