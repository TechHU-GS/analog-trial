* === Std Cell Definitions ===
.subckt sg13g2_dfrbp_1 Q Q_N CLK D RESET_B VDD VSS
XN13 net12 net2 VSS VSS sg13_lv_nmos w=420.00n l=130.00n ng=1 ad=1.428e-13 as=1.428e-13 pd=1.52e-06 ps=1.52e-06 m=1
XN14 net5 clkneg net12 VSS sg13_lv_nmos w=420.00n l=130.00n ng=1 ad=1.428e-13 as=1.428e-13 pd=1.52e-06 ps=1.52e-06 m=1
XN15 net2 net5 net11 VSS sg13_lv_nmos w=420.00n l=130.00n ng=1 ad=1.428e-13 as=1.428e-13 pd=1.52e-06 ps=1.52e-06 m=1
XN16 net11 RESET_B VSS VSS sg13_lv_nmos w=420.00n l=130.00n ng=1 ad=1.428e-13 as=1.428e-13 pd=1.52e-06 ps=1.52e-06 m=1
XN6 Q_N net5 VSS VSS sg13_lv_nmos w=740.00n l=130.00n ng=1 ad=2.516e-13 as=2.516e-13 pd=2.16e-06 ps=2.16e-06 m=1
XN0 Db D net10 VSS sg13_lv_nmos w=420.00n l=130.00n ng=1 ad=1.428e-13 as=1.428e-13 pd=1.52e-06 ps=1.52e-06 m=1
XN1 net10 RESET_B VSS VSS sg13_lv_nmos w=420.00n l=130.00n ng=1 ad=1.428e-13 as=1.428e-13 pd=1.52e-06 ps=1.52e-06 m=1
XN7 Db clkneg net6 VSS sg13_lv_nmos w=420.00n l=130.00n ng=1 ad=1.428e-13 as=1.428e-13 pd=1.52e-06 ps=1.52e-06 m=1
XN8 net6 clkpos net9 VSS sg13_lv_nmos w=420.00n l=130.00n ng=1 ad=1.428e-13 as=1.428e-13 pd=1.52e-06 ps=1.52e-06 m=1
XN9 net9 net4 net8 VSS sg13_lv_nmos w=420.00n l=130.00n ng=1 ad=1.428e-13 as=1.428e-13 pd=1.52e-06 ps=1.52e-06 m=1
XN10 net8 RESET_B VSS VSS sg13_lv_nmos w=420.00n l=130.00n ng=1 ad=1.428e-13 as=1.428e-13 pd=1.52e-06 ps=1.52e-06 m=1
XN11 net4 net6 VSS VSS sg13_lv_nmos w=740.00n l=130.00n ng=1 ad=2.516e-13 as=2.516e-13 pd=2.16e-06 ps=2.16e-06 m=1
XN2 clkneg CLK VSS VSS sg13_lv_nmos w=740.00n l=130.00n ng=1 ad=2.516e-13 as=2.516e-13 pd=2.16e-06 ps=2.16e-06 m=1
XN12 net4 clkpos net5 VSS sg13_lv_nmos w=740.00n l=130.00n ng=1 ad=2.516e-13 as=2.516e-13 pd=2.16e-06 ps=2.16e-06 m=1
XN3 clkpos clkneg VSS VSS sg13_lv_nmos w=740.00n l=130.00n ng=1 ad=2.516e-13 as=2.516e-13 pd=2.16e-06 ps=2.16e-06 m=1
XN4 Q net1 VSS VSS sg13_lv_nmos w=740.00n l=130.00n ng=1 ad=2.516e-13 as=2.516e-13 pd=2.16e-06 ps=2.16e-06 m=1
XN5 net1 net5 VSS VSS sg13_lv_nmos w=740.00n l=130.00n ng=1 ad=2.516e-13 as=2.516e-13 pd=2.16e-06 ps=2.16e-06 m=1
XP14 net5 clkpos net3 VDD sg13_lv_pmos w=420.00n l=130.00n ng=1 ad=1.428e-13 as=1.428e-13 pd=1.52e-06 ps=1.52e-06 m=1
XP15 net2 net5 VDD VDD sg13_lv_pmos w=420.00n l=130.00n ng=1 ad=1.428e-13 as=1.428e-13 pd=1.52e-06 ps=1.52e-06 m=1
XP16 net2 RESET_B VDD VDD sg13_lv_pmos w=420.00n l=130.00n ng=1 ad=1.428e-13 as=1.428e-13 pd=1.52e-06 ps=1.52e-06 m=1
XP6 Q_N net5 VDD VDD sg13_lv_pmos w=1.12u l=130.00n ng=1 ad=3.808e-13 as=3.808e-13 pd=2.92e-06 ps=2.92e-06 m=1
XP7 Db clkpos net6 VDD sg13_lv_pmos w=420.00n l=130.00n ng=1 ad=1.428e-13 as=1.428e-13 pd=1.52e-06 ps=1.52e-06 m=1
XP0 Db RESET_B VDD VDD sg13_lv_pmos w=420.00n l=130.00n ng=1 ad=1.428e-13 as=1.428e-13 pd=1.52e-06 ps=1.52e-06 m=1
XP1 Db D VDD VDD sg13_lv_pmos w=420.00n l=130.00n ng=1 ad=1.428e-13 as=1.428e-13 pd=1.52e-06 ps=1.52e-06 m=1
XP8 net7 net4 VDD VDD sg13_lv_pmos w=420.00n l=130.00n ng=1 ad=1.428e-13 as=1.428e-13 pd=1.52e-06 ps=1.52e-06 m=1
XP9 net6 clkneg net7 VDD sg13_lv_pmos w=420.00n l=130.00n ng=1 ad=1.428e-13 as=1.428e-13 pd=1.52e-06 ps=1.52e-06 m=1
XP10 net6 RESET_B VDD VDD sg13_lv_pmos w=420.00n l=130.00n ng=1 ad=1.428e-13 as=1.428e-13 pd=1.52e-06 ps=1.52e-06 m=1
XP2 clkneg CLK VDD VDD sg13_lv_pmos w=1.12u l=130.00n ng=1 ad=3.808e-13 as=3.808e-13 pd=2.92e-06 ps=2.92e-06 m=1
XP3 clkpos clkneg VDD VDD sg13_lv_pmos w=1.12u l=130.00n ng=1 ad=3.808e-13 as=3.808e-13 pd=2.92e-06 ps=2.92e-06 m=1
XP11 net4 net6 VDD VDD sg13_lv_pmos w=1.000u l=130.00n ng=1 ad=3.4e-13 as=3.4e-13 pd=2.68e-06 ps=2.68e-06 m=1
XP12 net4 clkneg net5 VDD sg13_lv_pmos w=1.000u l=130.00n ng=1 ad=3.4e-13 as=3.4e-13 pd=2.68e-06 ps=2.68e-06 m=1
XP4 Q net1 VDD VDD sg13_lv_pmos w=1.12u l=130.00n ng=1 ad=3.808e-13 as=3.808e-13 pd=2.92e-06 ps=2.92e-06 m=1
XP13 net3 net2 VDD VDD sg13_lv_pmos w=420.00n l=130.00n ng=1 ad=1.428e-13 as=1.428e-13 pd=1.52e-06 ps=1.52e-06 m=1
XP5 net1 net5 VDD VDD sg13_lv_pmos w=1.12u l=130.00n ng=1 ad=3.808e-13 as=3.808e-13 pd=2.92e-06 ps=2.92e-06 m=1
.ends

.subckt sg13g2_inv_1 Y A VDD VSS
XX1 Y A VSS VSS sg13_lv_nmos w=740.00n l=130.00n ng=1 ad=2.516e-13 as=2.516e-13 pd=2.16e-06 ps=2.16e-06 m=1
XX0 Y A VDD VDD sg13_lv_pmos w=1.12u l=130.00n ng=1 ad=3.808e-13 as=3.808e-13 pd=2.92e-06 ps=2.92e-06 m=1
.ends

.subckt sg13g2_inv_2 Y A VDD VSS
XX1 Y A VSS VSS sg13_lv_nmos w=1.48u l=130.00n ng=2 ad=2.812e-13 as=5.032e-13 pd=2.24e-06 ps=4.32e-06 m=1
XX0 Y A VDD VDD sg13_lv_pmos w=2.24u l=130.00n ng=2 ad=4.256e-13 as=7.616e-13 pd=3e-06 ps=5.84e-06 m=1
.ends

.subckt sg13g2_mux2_1 X A0 A1 S VDD VSS
XP0 net4 S VDD VDD sg13_lv_pmos w=1.000u l=130.00n ng=1 ad=3.4e-13 as=3.4e-13 pd=2.68e-06 ps=2.68e-06 m=1
XP4 X net6 VDD VDD sg13_lv_pmos w=1.12u l=130.00n ng=1 ad=3.808e-13 as=3.808e-13 pd=2.92e-06 ps=2.92e-06 m=1
XP3 net6 A1 net5 VDD sg13_lv_pmos w=1.000u l=130.00n ng=1 ad=3.4e-13 as=3.4e-13 pd=2.68e-06 ps=2.68e-06 m=1
XP5 Sb S VDD VDD sg13_lv_pmos w=840.00n l=130.00n ng=1 ad=2.856e-13 as=2.856e-13 pd=2.36e-06 ps=2.36e-06 m=1
XP2 net5 Sb VDD VDD sg13_lv_pmos w=1.000u l=130.00n ng=1 ad=3.4e-13 as=3.4e-13 pd=2.68e-06 ps=2.68e-06 m=1
XP1 net6 A0 net4 VDD sg13_lv_pmos w=1.000u l=130.00n ng=1 ad=3.4e-13 as=3.4e-13 pd=2.68e-06 ps=2.68e-06 m=1
XN4 net3 S VSS VSS sg13_lv_nmos w=740.00n l=130.00n ng=1 ad=2.516e-13 as=2.516e-13 pd=2.16e-06 ps=2.16e-06 m=1
XN1 net1 Sb VSS VSS sg13_lv_nmos w=740.00n l=130.00n ng=1 ad=2.516e-13 as=2.516e-13 pd=2.16e-06 ps=2.16e-06 m=1
XN6 X net6 VSS VSS sg13_lv_nmos w=740.00n l=130.00n ng=1 ad=2.516e-13 as=2.516e-13 pd=2.16e-06 ps=2.16e-06 m=1
XN5 Sb S VSS VSS sg13_lv_nmos w=550.00n l=130.00n ng=1 ad=1.87e-13 as=1.87e-13 pd=1.78e-06 ps=1.78e-06 m=1
XN2 net6 A1 net3 VSS sg13_lv_nmos w=740.00n l=130.00n ng=1 ad=2.516e-13 as=2.516e-13 pd=2.16e-06 ps=2.16e-06 m=1
XN0 net6 A0 net1 VSS sg13_lv_nmos w=740.00n l=130.00n ng=1 ad=2.516e-13 as=2.516e-13 pd=2.16e-06 ps=2.16e-06 m=1
.ends

.subckt sg13g2_nand2_1 Y A B VDD VSS
XP1 Y B VDD VDD sg13_lv_pmos w=1.12u l=130.00n ng=1 ad=3.808e-13 as=3.808e-13 pd=2.92e-06 ps=2.92e-06 m=1
XP0 Y A VDD VDD sg13_lv_pmos w=1.12u l=130.00n ng=1 ad=3.808e-13 as=3.808e-13 pd=2.92e-06 ps=2.92e-06 m=1
XN1 net1 B VSS VSS sg13_lv_nmos w=740.00n l=130.00n ng=1 ad=2.516e-13 as=2.516e-13 pd=2.16e-06 ps=2.16e-06 m=1
XN0 Y A net1 VSS sg13_lv_nmos w=740.00n l=130.00n ng=1 ad=2.516e-13 as=2.516e-13 pd=2.16e-06 ps=2.16e-06 m=1
.ends

.subckt tt_um_techhu_analog_trial gnd vdd
MPM3 net_c1 net_c1 vdd vdd sg13_lv_pmos w=0.5u l=10u ng=1 m=1
MPM4 net_c2 net_c1 vdd vdd sg13_lv_pmos w=0.5u l=10u ng=1 m=1
MMN1 net_c1 net_c1 0 0 sg13_lv_nmos w=2u l=4u ng=1 m=1
* Expanded MMN2 ng=8 -> 8x w=2.0u
MMN2_0 net_c2 net_c1 net_rptat 0 sg13_lv_nmos w=2.0u l=4u ng=1 m=1
MMN2_1 net_rptat net_c1 net_c2 0 sg13_lv_nmos w=2.0u l=4u ng=1 m=1
MMN2_2 net_c2 net_c1 net_rptat 0 sg13_lv_nmos w=2.0u l=4u ng=1 m=1
MMN2_3 net_rptat net_c1 net_c2 0 sg13_lv_nmos w=2.0u l=4u ng=1 m=1
MMN2_4 net_c2 net_c1 net_rptat 0 sg13_lv_nmos w=2.0u l=4u ng=1 m=1
MMN2_5 net_rptat net_c1 net_c2 0 sg13_lv_nmos w=2.0u l=4u ng=1 m=1
MMN2_6 net_c2 net_c1 net_rptat 0 sg13_lv_nmos w=2.0u l=4u ng=1 m=1
MMN2_7 net_rptat net_c1 net_c2 0 sg13_lv_nmos w=2.0u l=4u ng=1 m=1
RRptat net_rptat 0 0 rhigh w=0.5e-6 l=133.0e-6 b=12 m=1
MPM_ref nmos_bias net_c1 vdd vdd sg13_lv_pmos w=0.5u l=10u ng=1 m=1
MMN_diode nmos_bias nmos_bias 0 0 sg13_lv_nmos w=1u l=2u ng=1 m=1
MMN_pgen pmos_bias nmos_bias 0 0 sg13_lv_nmos w=1u l=2u ng=1 m=1
MPM_pdiode pmos_bias pmos_bias vdd vdd sg13_lv_pmos w=0.5u l=2u ng=1 m=1
MPM5 vptat net_c1 vdd vdd sg13_lv_pmos w=0.5u l=10u ng=1 m=1
RRout vptat 0 0 rppd w=0.5e-6 l=25.0e-6 b=4 m=1
* Expanded MMpb1 ng=8 -> 8x w=0.5u
MMpb1_0 ns1 pmos_bias vdd vdd sg13_lv_pmos w=0.5u l=2u ng=1 m=1
MMpb1_1 vdd pmos_bias ns1 vdd sg13_lv_pmos w=0.5u l=2u ng=1 m=1
MMpb1_2 ns1 pmos_bias vdd vdd sg13_lv_pmos w=0.5u l=2u ng=1 m=1
MMpb1_3 vdd pmos_bias ns1 vdd sg13_lv_pmos w=0.5u l=2u ng=1 m=1
MMpb1_4 ns1 pmos_bias vdd vdd sg13_lv_pmos w=0.5u l=2u ng=1 m=1
MMpb1_5 vdd pmos_bias ns1 vdd sg13_lv_pmos w=0.5u l=2u ng=1 m=1
MMpb1_6 ns1 pmos_bias vdd vdd sg13_lv_pmos w=0.5u l=2u ng=1 m=1
MMpb1_7 vdd pmos_bias ns1 vdd sg13_lv_pmos w=0.5u l=2u ng=1 m=1
MMpu1 vco1 vco5 ns1 vdd sg13_lv_pmos w=2u l=0.5u ng=1 m=1
MMpd1 vco1 vco5 nb1 0 sg13_lv_nmos w=1u l=0.5u ng=1 m=1
* Expanded MMnb1 ng=8 -> 8x w=1.0u
MMnb1_0 nb1 nmos_bias 0 0 sg13_lv_nmos w=1.0u l=2u ng=1 m=1
MMnb1_1 0 nmos_bias nb1 0 sg13_lv_nmos w=1.0u l=2u ng=1 m=1
MMnb1_2 nb1 nmos_bias 0 0 sg13_lv_nmos w=1.0u l=2u ng=1 m=1
MMnb1_3 0 nmos_bias nb1 0 sg13_lv_nmos w=1.0u l=2u ng=1 m=1
MMnb1_4 nb1 nmos_bias 0 0 sg13_lv_nmos w=1.0u l=2u ng=1 m=1
MMnb1_5 0 nmos_bias nb1 0 sg13_lv_nmos w=1.0u l=2u ng=1 m=1
MMnb1_6 nb1 nmos_bias 0 0 sg13_lv_nmos w=1.0u l=2u ng=1 m=1
MMnb1_7 0 nmos_bias nb1 0 sg13_lv_nmos w=1.0u l=2u ng=1 m=1
* Expanded MMpb2 ng=8 -> 8x w=0.5u
MMpb2_0 ns2 pmos_bias vdd vdd sg13_lv_pmos w=0.5u l=2u ng=1 m=1
MMpb2_1 vdd pmos_bias ns2 vdd sg13_lv_pmos w=0.5u l=2u ng=1 m=1
MMpb2_2 ns2 pmos_bias vdd vdd sg13_lv_pmos w=0.5u l=2u ng=1 m=1
MMpb2_3 vdd pmos_bias ns2 vdd sg13_lv_pmos w=0.5u l=2u ng=1 m=1
MMpb2_4 ns2 pmos_bias vdd vdd sg13_lv_pmos w=0.5u l=2u ng=1 m=1
MMpb2_5 vdd pmos_bias ns2 vdd sg13_lv_pmos w=0.5u l=2u ng=1 m=1
MMpb2_6 ns2 pmos_bias vdd vdd sg13_lv_pmos w=0.5u l=2u ng=1 m=1
MMpb2_7 vdd pmos_bias ns2 vdd sg13_lv_pmos w=0.5u l=2u ng=1 m=1
MMpu2 vco2 vco1 ns2 vdd sg13_lv_pmos w=2u l=0.5u ng=1 m=1
MMpd2 vco2 vco1 nb2 0 sg13_lv_nmos w=1u l=0.5u ng=1 m=1
* Expanded MMnb2 ng=8 -> 8x w=1.0u
MMnb2_0 nb2 nmos_bias 0 0 sg13_lv_nmos w=1.0u l=2u ng=1 m=1
MMnb2_1 0 nmos_bias nb2 0 sg13_lv_nmos w=1.0u l=2u ng=1 m=1
MMnb2_2 nb2 nmos_bias 0 0 sg13_lv_nmos w=1.0u l=2u ng=1 m=1
MMnb2_3 0 nmos_bias nb2 0 sg13_lv_nmos w=1.0u l=2u ng=1 m=1
MMnb2_4 nb2 nmos_bias 0 0 sg13_lv_nmos w=1.0u l=2u ng=1 m=1
MMnb2_5 0 nmos_bias nb2 0 sg13_lv_nmos w=1.0u l=2u ng=1 m=1
MMnb2_6 nb2 nmos_bias 0 0 sg13_lv_nmos w=1.0u l=2u ng=1 m=1
MMnb2_7 0 nmos_bias nb2 0 sg13_lv_nmos w=1.0u l=2u ng=1 m=1
* Expanded MMpb3 ng=8 -> 8x w=0.5u
MMpb3_0 ns3 pmos_bias vdd vdd sg13_lv_pmos w=0.5u l=2u ng=1 m=1
MMpb3_1 vdd pmos_bias ns3 vdd sg13_lv_pmos w=0.5u l=2u ng=1 m=1
MMpb3_2 ns3 pmos_bias vdd vdd sg13_lv_pmos w=0.5u l=2u ng=1 m=1
MMpb3_3 vdd pmos_bias ns3 vdd sg13_lv_pmos w=0.5u l=2u ng=1 m=1
MMpb3_4 ns3 pmos_bias vdd vdd sg13_lv_pmos w=0.5u l=2u ng=1 m=1
MMpb3_5 vdd pmos_bias ns3 vdd sg13_lv_pmos w=0.5u l=2u ng=1 m=1
MMpb3_6 ns3 pmos_bias vdd vdd sg13_lv_pmos w=0.5u l=2u ng=1 m=1
MMpb3_7 vdd pmos_bias ns3 vdd sg13_lv_pmos w=0.5u l=2u ng=1 m=1
MMpu3 vco3 vco2 ns3 vdd sg13_lv_pmos w=2u l=0.5u ng=1 m=1
MMpd3 vco3 vco2 nb3 0 sg13_lv_nmos w=1u l=0.5u ng=1 m=1
* Expanded MMnb3 ng=8 -> 8x w=1.0u
MMnb3_0 nb3 nmos_bias 0 0 sg13_lv_nmos w=1.0u l=2u ng=1 m=1
MMnb3_1 0 nmos_bias nb3 0 sg13_lv_nmos w=1.0u l=2u ng=1 m=1
MMnb3_2 nb3 nmos_bias 0 0 sg13_lv_nmos w=1.0u l=2u ng=1 m=1
MMnb3_3 0 nmos_bias nb3 0 sg13_lv_nmos w=1.0u l=2u ng=1 m=1
MMnb3_4 nb3 nmos_bias 0 0 sg13_lv_nmos w=1.0u l=2u ng=1 m=1
MMnb3_5 0 nmos_bias nb3 0 sg13_lv_nmos w=1.0u l=2u ng=1 m=1
MMnb3_6 nb3 nmos_bias 0 0 sg13_lv_nmos w=1.0u l=2u ng=1 m=1
MMnb3_7 0 nmos_bias nb3 0 sg13_lv_nmos w=1.0u l=2u ng=1 m=1
* Expanded MMpb4 ng=8 -> 8x w=0.5u
MMpb4_0 ns4 pmos_bias vdd vdd sg13_lv_pmos w=0.5u l=2u ng=1 m=1
MMpb4_1 vdd pmos_bias ns4 vdd sg13_lv_pmos w=0.5u l=2u ng=1 m=1
MMpb4_2 ns4 pmos_bias vdd vdd sg13_lv_pmos w=0.5u l=2u ng=1 m=1
MMpb4_3 vdd pmos_bias ns4 vdd sg13_lv_pmos w=0.5u l=2u ng=1 m=1
MMpb4_4 ns4 pmos_bias vdd vdd sg13_lv_pmos w=0.5u l=2u ng=1 m=1
MMpb4_5 vdd pmos_bias ns4 vdd sg13_lv_pmos w=0.5u l=2u ng=1 m=1
MMpb4_6 ns4 pmos_bias vdd vdd sg13_lv_pmos w=0.5u l=2u ng=1 m=1
MMpb4_7 vdd pmos_bias ns4 vdd sg13_lv_pmos w=0.5u l=2u ng=1 m=1
MMpu4 vco4 vco3 ns4 vdd sg13_lv_pmos w=2u l=0.5u ng=1 m=1
MMpd4 vco4 vco3 nb4 0 sg13_lv_nmos w=1u l=0.5u ng=1 m=1
* Expanded MMnb4 ng=8 -> 8x w=1.0u
MMnb4_0 nb4 nmos_bias 0 0 sg13_lv_nmos w=1.0u l=2u ng=1 m=1
MMnb4_1 0 nmos_bias nb4 0 sg13_lv_nmos w=1.0u l=2u ng=1 m=1
MMnb4_2 nb4 nmos_bias 0 0 sg13_lv_nmos w=1.0u l=2u ng=1 m=1
MMnb4_3 0 nmos_bias nb4 0 sg13_lv_nmos w=1.0u l=2u ng=1 m=1
MMnb4_4 nb4 nmos_bias 0 0 sg13_lv_nmos w=1.0u l=2u ng=1 m=1
MMnb4_5 0 nmos_bias nb4 0 sg13_lv_nmos w=1.0u l=2u ng=1 m=1
MMnb4_6 nb4 nmos_bias 0 0 sg13_lv_nmos w=1.0u l=2u ng=1 m=1
MMnb4_7 0 nmos_bias nb4 0 sg13_lv_nmos w=1.0u l=2u ng=1 m=1
* Expanded MMpb5 ng=8 -> 8x w=0.5u
MMpb5_0 ns5 pmos_bias vdd vdd sg13_lv_pmos w=0.5u l=2u ng=1 m=1
MMpb5_1 vdd pmos_bias ns5 vdd sg13_lv_pmos w=0.5u l=2u ng=1 m=1
MMpb5_2 ns5 pmos_bias vdd vdd sg13_lv_pmos w=0.5u l=2u ng=1 m=1
MMpb5_3 vdd pmos_bias ns5 vdd sg13_lv_pmos w=0.5u l=2u ng=1 m=1
MMpb5_4 ns5 pmos_bias vdd vdd sg13_lv_pmos w=0.5u l=2u ng=1 m=1
MMpb5_5 vdd pmos_bias ns5 vdd sg13_lv_pmos w=0.5u l=2u ng=1 m=1
MMpb5_6 ns5 pmos_bias vdd vdd sg13_lv_pmos w=0.5u l=2u ng=1 m=1
MMpb5_7 vdd pmos_bias ns5 vdd sg13_lv_pmos w=0.5u l=2u ng=1 m=1
MMpu5 vco5 vco4 ns5 vdd sg13_lv_pmos w=2u l=0.5u ng=1 m=1
MMpd5 vco5 vco4 nb5 0 sg13_lv_nmos w=1u l=0.5u ng=1 m=1
* Expanded MMnb5 ng=8 -> 8x w=1.0u
MMnb5_0 nb5 nmos_bias 0 0 sg13_lv_nmos w=1.0u l=2u ng=1 m=1
MMnb5_1 0 nmos_bias nb5 0 sg13_lv_nmos w=1.0u l=2u ng=1 m=1
MMnb5_2 nb5 nmos_bias 0 0 sg13_lv_nmos w=1.0u l=2u ng=1 m=1
MMnb5_3 0 nmos_bias nb5 0 sg13_lv_nmos w=1.0u l=2u ng=1 m=1
MMnb5_4 nb5 nmos_bias 0 0 sg13_lv_nmos w=1.0u l=2u ng=1 m=1
MMnb5_5 0 nmos_bias nb5 0 sg13_lv_nmos w=1.0u l=2u ng=1 m=1
MMnb5_6 nb5 nmos_bias 0 0 sg13_lv_nmos w=1.0u l=2u ng=1 m=1
MMnb5_7 0 nmos_bias nb5 0 sg13_lv_nmos w=1.0u l=2u ng=1 m=1
MMBp1 buf1 vco5 vdd vdd sg13_lv_pmos w=4u l=0.5u ng=1 m=1
MMBn1 buf1 vco5 0 0 sg13_lv_nmos w=2u l=0.5u ng=1 m=1
* Expanded MMBp2 ng=2 -> 2x w=4.0u
MMBp2_0 vco_out buf1 vdd vdd sg13_lv_pmos w=4.0u l=0.5u ng=1 m=1
MMBp2_1 vdd buf1 vco_out vdd sg13_lv_pmos w=4.0u l=0.5u ng=1 m=1
* Expanded MMBn2 ng=2 -> 2x w=2.0u
MMBn2_0 vco_out buf1 0 0 sg13_lv_nmos w=2.0u l=0.5u ng=1 m=1
MMBn2_1 0 buf1 vco_out 0 sg13_lv_nmos w=2.0u l=0.5u ng=1 m=1
MPM_cas_ref cas_ref net_c1 vdd vdd sg13_lv_pmos w=1u l=10u ng=1 m=1
MPM_cas_diode vcas vcas cas_ref vdd sg13_lv_pmos w=1u l=2u ng=1 m=1
MMN_cas_load vcas vcas 0 0 sg13_lv_nmos w=0.5u l=2u ng=1 m=1
MPM_mir1 cas1 net_c1 vdd vdd sg13_lv_pmos w=1u l=10u ng=1 m=1
MPM_cas1 src1 vcas cas1 vdd sg13_lv_pmos w=1u l=2u ng=1 m=1
MPM_mir2 cas2 net_c1 vdd vdd sg13_lv_pmos w=2u l=10u ng=1 m=1
MPM_cas2 src2 vcas cas2 vdd sg13_lv_pmos w=2u l=2u ng=1 m=1
* Expanded MPM_mir3 ng=2 -> 2x w=2.0u
MPM_mir3_0 cas3 net_c1 vdd vdd sg13_lv_pmos w=2.0u l=10u ng=1 m=1
MPM_mir3_1 vdd net_c1 cas3 vdd sg13_lv_pmos w=2.0u l=10u ng=1 m=1
* Expanded MPM_cas3 ng=2 -> 2x w=2.0u
MPM_cas3_0 src3 vcas cas3 vdd sg13_lv_pmos w=2.0u l=2u ng=1 m=1
MPM_cas3_1 cas3 vcas src3 vdd sg13_lv_pmos w=2.0u l=2u ng=1 m=1
MSW1n src1 sel0 exc_out 0 sg13_lv_nmos w=2u l=0.5u ng=1 m=1
MSW1p src1 sel0b exc_out vdd sg13_lv_pmos w=4u l=0.5u ng=1 m=1
MSW2n src2 sel1 exc_out 0 sg13_lv_nmos w=2u l=0.5u ng=1 m=1
MSW2p src2 sel1b exc_out vdd sg13_lv_pmos w=4u l=0.5u ng=1 m=1
MSW3n src3 sel2 exc_out 0 sg13_lv_nmos w=2u l=0.5u ng=1 m=1
MSW3p src3 sel2b exc_out vdd sg13_lv_pmos w=4u l=0.5u ng=1 m=1
* Expanded MMS1 ng=2 -> 2x w=2.0u
MMS1_0 exc_out phi_p probe_p 0 sg13_lv_nmos w=2.0u l=0.5u ng=1 m=1
MMS1_1 probe_p phi_p exc_out 0 sg13_lv_nmos w=2.0u l=0.5u ng=1 m=1
* Expanded MMS2 ng=2 -> 2x w=2.0u
MMS2_0 0 phi_n probe_p 0 sg13_lv_nmos w=2.0u l=0.5u ng=1 m=1
MMS2_1 probe_p phi_n 0 0 sg13_lv_nmos w=2.0u l=0.5u ng=1 m=1
* Expanded MMS3 ng=2 -> 2x w=2.0u
MMS3_0 exc_out phi_n probe_n 0 sg13_lv_nmos w=2.0u l=0.5u ng=1 m=1
MMS3_1 probe_n phi_n exc_out 0 sg13_lv_nmos w=2.0u l=0.5u ng=1 m=1
* Expanded MMS4 ng=2 -> 2x w=2.0u
MMS4_0 0 phi_p probe_n 0 sg13_lv_nmos w=2.0u l=0.5u ng=1 m=1
MMS4_1 probe_n phi_p 0 0 sg13_lv_nmos w=2.0u l=0.5u ng=1 m=1
MMchop1n sens_p f_exc chop_out 0 sg13_lv_nmos w=2u l=0.5u ng=1 m=1
MMchop1p sens_p f_exc_b chop_out vdd sg13_lv_pmos w=4u l=0.5u ng=1 m=1
MMchop2n sens_n f_exc_b chop_out 0 sg13_lv_nmos w=2u l=0.5u ng=1 m=1
MMchop2p sens_n f_exc chop_out vdd sg13_lv_pmos w=4u l=0.5u ng=1 m=1
MMbias_d bias_n bias_n 0 0 sg13_lv_nmos w=4u l=4u ng=1 m=1
MMp_load_p mid_p mid_p vdd vdd sg13_lv_pmos w=4u l=4u ng=1 m=1
MMp_load_n ota_out mid_p vdd vdd sg13_lv_pmos w=4u l=4u ng=1 m=1
* Expanded MMin_p ng=4 -> 4x w=2.5u
MMin_p_0 mid_p vref_ota tail 0 sg13_lv_nmos w=2.5u l=2u ng=1 m=1
MMin_p_1 tail vref_ota mid_p 0 sg13_lv_nmos w=2.5u l=2u ng=1 m=1
MMin_p_2 mid_p vref_ota tail 0 sg13_lv_nmos w=2.5u l=2u ng=1 m=1
MMin_p_3 tail vref_ota mid_p 0 sg13_lv_nmos w=2.5u l=2u ng=1 m=1
* Expanded MMin_n ng=4 -> 4x w=2.5u
MMin_n_0 ota_out sum_n tail 0 sg13_lv_nmos w=2.5u l=2u ng=1 m=1
MMin_n_1 tail sum_n ota_out 0 sg13_lv_nmos w=2.5u l=2u ng=1 m=1
MMin_n_2 ota_out sum_n tail 0 sg13_lv_nmos w=2.5u l=2u ng=1 m=1
MMin_n_3 tail sum_n ota_out 0 sg13_lv_nmos w=2.5u l=2u ng=1 m=1
* Expanded MMtail ng=2 -> 2x w=4.0u
MMtail_0 tail bias_n 0 0 sg13_lv_nmos w=4.0u l=4u ng=1 m=1
MMtail_1 0 bias_n tail 0 sg13_lv_nmos w=4.0u l=4u ng=1 m=1
* Expanded MMc_tail ng=2 -> 2x w=2.0u
MMc_tail_0 c_tail comp_clk 0 0 sg13_lv_nmos w=2.0u l=0.5u ng=1 m=1
MMc_tail_1 0 comp_clk c_tail 0 sg13_lv_nmos w=2.0u l=0.5u ng=1 m=1
* Expanded MMc_inp ng=2 -> 2x w=2.0u
MMc_inp_0 c_di_p ota_out c_tail 0 sg13_lv_nmos w=2.0u l=0.5u ng=1 m=1
MMc_inp_1 c_tail ota_out c_di_p 0 sg13_lv_nmos w=2.0u l=0.5u ng=1 m=1
* Expanded MMc_inn ng=2 -> 2x w=2.0u
MMc_inn_0 c_di_n vref_comp c_tail 0 sg13_lv_nmos w=2.0u l=0.5u ng=1 m=1
MMc_inn_1 c_tail vref_comp c_di_n 0 sg13_lv_nmos w=2.0u l=0.5u ng=1 m=1
MMc_rst_dp c_di_p comp_clk vdd vdd sg13_lv_pmos w=2u l=0.5u ng=1 m=1
MMc_rst_dn c_di_n comp_clk vdd vdd sg13_lv_pmos w=2u l=0.5u ng=1 m=1
MMc_ln1 comp_outp comp_outn c_di_p 0 sg13_lv_nmos w=1u l=0.5u ng=1 m=1
MMc_ln2 comp_outn comp_outp c_di_n 0 sg13_lv_nmos w=1u l=0.5u ng=1 m=1
MMc_lp1 comp_outp comp_outn vdd vdd sg13_lv_pmos w=1u l=0.5u ng=1 m=1
MMc_lp2 comp_outn comp_outp vdd vdd sg13_lv_pmos w=1u l=0.5u ng=1 m=1
MMc_rst_op comp_outp comp_clk vdd vdd sg13_lv_pmos w=2u l=0.5u ng=1 m=1
MMc_rst_on comp_outn comp_clk vdd vdd sg13_lv_pmos w=2u l=0.5u ng=1 m=1
MMn1a n1_mid comp_outp 0 0 sg13_lv_nmos w=2u l=0.5u ng=1 m=1
MMp1a lat_q comp_outp vdd vdd sg13_lv_pmos w=2u l=0.5u ng=1 m=1
MMn1b lat_q lat_qb n1_mid 0 sg13_lv_nmos w=2u l=0.5u ng=1 m=1
MMp1b lat_q lat_qb vdd vdd sg13_lv_pmos w=2u l=0.5u ng=1 m=1
MMn2a n2_mid comp_outn 0 0 sg13_lv_nmos w=2u l=0.5u ng=1 m=1
MMp2a lat_qb comp_outn vdd vdd sg13_lv_pmos w=2u l=0.5u ng=1 m=1
MMn2b lat_qb lat_q n2_mid 0 sg13_lv_nmos w=2u l=0.5u ng=1 m=1
MMp2b lat_qb lat_q vdd vdd sg13_lv_pmos w=2u l=0.5u ng=1 m=1
MMdac_tg1n dac_hi lat_q dac_out 0 sg13_lv_nmos w=2u l=0.5u ng=1 m=1
MMdac_tg1p dac_hi lat_qb dac_out vdd sg13_lv_pmos w=4u l=0.5u ng=1 m=1
MMdac_tg2n dac_lo lat_qb dac_out 0 sg13_lv_nmos w=2u l=0.5u ng=1 m=1
MMdac_tg2p dac_lo lat_q dac_out vdd sg13_lv_pmos w=4u l=0.5u ng=1 m=1
RRin chop_out sum_n 0 rhigh w=0.5e-6 l=20.0e-6 b=2 m=1
RRdac dac_out sum_n 0 rhigh w=0.5e-6 l=20.0e-6 b=2 m=1
CC_fb ota_out sum_n cap_cmim w=26.0e-6 l=26.0e-6 m=1
CCbyp_n nmos_bias gnd cap_cmim w=5.0u l=5.0u m=1
CCbyp_p pmos_bias gnd cap_cmim w=5.0u l=5.0u m=1

* === Digital Instances ===
XINV_VCO vco_b vco_out vdd gnd sg13g2_inv_1
XINV_iso vco_buf vco_out vdd gnd sg13g2_inv_2
XINV_isob vco_buf_b vco_buf vdd gnd sg13g2_inv_2
XT1I div2_I div2_I_b vco_buf_b div2_I_b reset_b vdd gnd sg13g2_dfrbp_1
XT1Q div2_Q div2_Q_b vco_buf div2_Q_b reset_b vdd gnd sg13g2_dfrbp_1
XT2I div4_I div4_I_b div2_I div4_I_b reset_b vdd gnd sg13g2_dfrbp_1
XT2Q div4_Q div4_Q_b div2_I div4_Q_b reset_b vdd gnd sg13g2_dfrbp_1
XT3 div8 div8_b div4_I div8_b reset_b vdd gnd sg13g2_dfrbp_1
XT4I div16_I div16_I_b div8 div16_I_b reset_b vdd gnd sg13g2_dfrbp_1
XT4Q div16_Q div16_Q_b div8 div16_Q_b reset_b vdd gnd sg13g2_dfrbp_1
XMXfi mxfi_out div4_I div16_I freq_sel vdd gnd sg13g2_mux2_1
XMXfq mxfq_out div4_Q div16_Q freq_sel vdd gnd sg13g2_mux2_1
XMXiq f_exc mxfi_out mxfq_out iq_sel vdd gnd sg13g2_mux2_1
XINV_exc f_exc_b f_exc vdd gnd sg13g2_inv_1
XBUF_I buf_ref_I ref_I vdd gnd sg13g2_inv_1
XBUF_Q buf_ref_Q ref_Q vdd gnd sg13g2_inv_1
XDA1 da1 f_exc vdd gnd sg13g2_inv_1
XDA2 f_exc_d da1 vdd gnd sg13g2_inv_1
XDB1 db1 f_exc_b vdd gnd sg13g2_inv_1
XDB2 f_exc_b_d db1 vdd gnd sg13g2_inv_1
XNA nand_a f_exc f_exc_d vdd gnd sg13g2_nand2_1
XIA phi_p nand_a vdd gnd sg13g2_inv_1
XNB nand_b f_exc_b f_exc_b_d vdd gnd sg13g2_nand2_1
XIB phi_n nand_b vdd gnd sg13g2_inv_1

.ends tt_um_techhu_analog_trial
