.subckt chopper chop_out sens_p sens_n f_exc f_exc_b gnd vdd
MMchop1n sens_p f_exc chop_out gnd sg13_lv_nmos w=2u l=0.5u ng=1 m=1
MMchop1p sens_p f_exc_b chop_out vdd sg13_lv_pmos w=4u l=0.5u ng=1 m=1
MMchop2n sens_n f_exc_b chop_out gnd sg13_lv_nmos w=2u l=0.5u ng=1 m=1
MMchop2p sens_n f_exc chop_out vdd sg13_lv_pmos w=4u l=0.5u ng=1 m=1
.ends chopper
